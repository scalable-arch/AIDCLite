addrmap AIDC_LITE_COMP_CFG {
    name = "AI Data Compressor";
    desc = "Register description of Sungkyunkwan University Scalable Architecture Lab's AIDCLite Compressor";

    default regwidth = 32;
    default sw = rw;
    default hw = r;

    reg {
        name = "Version Register";
        desc = "The version information of this IP";

        field {
            sw = r; hw = w;
            desc = "The major version of this IP. A change in major version indicates that the software needs changes. This document describes the behaviours of MAJOR version 1.";
        } MAJOR[31:24];
        field {
            sw = r; hw = w;
            desc = "The minor version of this IP. A change in minor version indicates that the hardware has undergone some changes yet its software interface has not changes.";
        } MINOR[23:16];
        field {
            sw = r; hw = w;
            desc = "The micro version of this IP. Every commit increases this version.";
        } MICRO[15:0];
    } VERSION @0x0;

    reg {
        name = "Git Hash Register";
        desc = "The Git version hash of this IP";

        field {
            sw = r; hw = w;
            desc = "The short Git version hash (upper 32-bit) of this IP";
        } HASH[31:0];
    } GIT @0x4;

    reg {
        name = "Source Register";
        desc = "The starting address of the to-be-compressed region";

        field {
            desc = "Specifies the source address (of uncompressed data)";
            sw = rw; hw = r;
            reset = 0;
        } START_ADDR[31:0];
    } SRC_ADDR @0x10;

    reg {
        name = "Destination Register";
        desc = "The starting address of the compressed region";

        field {
            desc = "Specifies the destination address (of compressed data)";
            sw = rw; hw = r;
            reset = 0;
        } START_ADDR[31:0];
    } DST_ADDR @0x14;

    reg {
        name = "Length Register";

        field {
            desc = "Specifies the size of the data to be compressed";
            sw = rw; hw = r;
            reset = 0;
        } BYTE_SIZE[31:7];
    } LEN @0x18;

    reg {
        name = "Command Register";

        field {
            singlepulse = 1; hw = r;
            reset = 0;
        } START[0:0];
    } CMD @0x1C;

    reg {
        name = "Status Register";
        field {
            sw = r; hw = w;
        } DONE[0:0];

    } STATUS @0x20;
};

addrmap AIDC_LITE_DECOMP_CFG {
    name = "AI Data Decompressor";
    desc = "Register description of Sungkyunkwan University Scalable Architecture Lab's AIDCLite Decompressor";

    default regwidth = 32;
    default sw = rw;
    default hw = r;

    reg {
        field {
            sw = r; hw = w;
            desc = "The major version of this IP. A change in major version indicates that the software needs changes. This document describes the behaviours of MAJOR version 1.";
        } MAJOR[31:24];
        field {
            sw = r; hw = w;
            desc = "The minor version of this IP. A change in minor version indicates that the hardware has undergone some changes yet its software interface has not changes.";
        } MINOR[23:16];
        field {
            sw = r; hw = w;
            desc = "The micro version of this IP. Every commit increases this version.";
        } MICRO[15:0];
        desc = "The version information of this IP";
    } VERSION @0x0;

    reg {
        field {
            sw = r; hw = w;
            desc = "The short Git version hash (upper 32-bit) of this IP";
        } HASH[31:0];
        desc = "The Git version hash of this IP";
    } GIT @0x4;

    reg {
        name = "Source Register";

        field {
            desc = "Specifies the source address (of compressed data)";
            sw = rw; hw = r;
            reset = 0;
        } START_ADDR[31:0];
    } SRC_ADDR @0x10;

    reg {
        name = "Destination Register";

        field {
            desc = "Specifies the destination address (of decompressed data)";
            sw = rw; hw = r;
            reset = 0;
        } START_ADDR[31:0];
    } DST_ADDR @0x14;

    reg {
        name = "Length Register";

        field {
            desc = "Specifies the size of the data to be decompressed";
            sw = rw; hw = r;
            reset = 0;
        } BYTE_SIZE[31:6];
    } LEN @0x18;

    reg {
        field {
            singlepulse = 1; hw = r;
            reset = 0;
        } START[0:0];
    } CMD @0x1C;

    reg {
        field {
            sw = r; hw = w;
        } DONE[0:0];

    } STATUS @0x20;
};
