addrmap AIDC_LITE_COMP_CFG {
    name = "AI Data Compressor";
    desc = "Register description of Sungkyunkwan University Scalable Architecture Lab's AIDCLite Compressor";

    default regwidth = 32;
    default sw = rw;
    default hw = r;

    reg {
        field {
            sw=r; hw=w;
        } MAJOR[31:24];
        field {
            sw=r; hw=w;
        } MINOR[23:16];
        field {
            sw=r; hw=w;
        } MICRO[15:0];
    } VERSION @0x0;

    reg {
        field {
            sw=r; hw=w;
        } HASH[31:0];
    } GIT @0x4;

    reg {
        name = "Source Register";

        field {
            desc = "Specifies the source address (of uncompressed data)";
            sw=rw; hw=r;
        } START_ADDR[31:0] = 0;
    } SRC_ADDR @0x10;

    reg {
        name = "Destination Register";

        field {
            desc = "Specifies the destination address (of compressed data)";
            sw=rw; hw=r;
        } START_ADDR[31:0] = 0;
    } DST_ADDR @0x14;

    reg {
        name = "Length Register";

        field {
            desc = "Specifies the size of the data to be compressed";
            sw=rw; hw=r;
        } BYTE_SIZE[31:7] = 0;
    } LEN @0x18;

    reg {
        field {
            singlepulse=1; hw=r;
            reset=0;
        } START[0:0];
    } CMD @0x1C;

    reg {
        field {
            sw=r; hw=w;
        } DONE[0:0];

    } STATUS @0x20;
};

addrmap AIDC_LITE_DECOMP_CFG {
    name = "AI Data Decompressor";
    desc = "Register description of Sungkyunkwan University Scalable Architecture Lab's AIDCLite Decompressor";

    default regwidth = 32;
    default sw = rw;
    default hw = r;

    reg {
        field {
            sw=r; hw=w;
        } MAJOR[31:24];
        field {
            sw=r; hw=w;
        } MINOR[23:16];
        field {
            sw=r; hw=w;
        } MICRO[15:0];
    } VERSION @0x0;

    reg {
        field {
            sw=r; hw=w;
        } HASH[31:0];
    } GIT @0x4;

    reg {
        name = "Source Register";

        field {
            desc = "Specifies the source address (of compressed data)";
            sw=rw; hw=r;
        } START_ADDR[31:0] = 0;
    } SRC_ADDR @0x10;

    reg {
        name = "Destination Register";

        field {
            desc = "Specifies the destination address (of decompressed data)";
            sw=rw; hw=r;
        } START_ADDR[31:0] = 0;
    } DST_ADDR @0x14;

    reg {
        name = "Length Register";

        field {
            desc = "Specifies the size of the data to be decompressed";
            sw=rw; hw=r;
        } BYTE_SIZE[31:6] = 0;
    } LEN @0x18;

    reg {
        field {
            singlepulse=1; hw=r;
            reset=0;
        } START[0:0];
    } CMD @0x1C;

    reg {
        field {
            sw=r; hw=w;
        } DONE[0:0];

    } STATUS @0x20;
};
